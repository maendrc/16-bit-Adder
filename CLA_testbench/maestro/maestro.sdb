ADE simulation setup
Run mode: Single Run, Sweeps and Corners
Tests:
  project2_tb_adder_CLA_1: project2/tb_adder_CLA/schematic, simulator spectre
    Variables: supply_voltage = 0.95:0.01:1.2
    Outputs: toutA; toutB; toutC; Power; PDP_A; PDP_B; PDP_C
