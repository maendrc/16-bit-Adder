ADE simulation setup
Run mode: Single Run, Sweeps and Corners
Tests:
  project2_tb_adder_1: project2/tb_adder_ripple2/schematic, simulator spectre
    Outputs: (max(cross(VT("/S15") 0.6 1 "rising") cross(VT("/Cout") 0.6 1 "rising")) - cross(VT("/A0") 0.6 1 "rising")); (max(cross(clip(VT("/S15") 0 5e-10) 0.6 1 "rising" nil nil nil) cross(clip(VT("/Cout") 0 5e-10) 0.6 1 "rising" nil nil nil)) - cross(clip(VT("/A0") 0 5e-10) 0.6 1 "rising" nil nil nil)); S15; C16; A15; toutB; toutC; (integ((abs(VT("/VDD")) * abs(IT("/V0/PLUS"))) 0 4e-09 " ") / 4e-09); power; PDP_A; toutA; "/S12"; PDP_B; PDP_C; S14; (max(cross(clip(VT("/S15") 0 9e-10) 0.6 1 "falling" nil nil nil) cross(clip(VT("/C16") 0 9e-10) 0.6 1 "rising" nil nil nil)) - cross(clip(VT("/A15") 0 9e-10) 0.6 1 "rising" nil nil nil)); (max(cross(clip(VT("/S14") 0 9e-10) 0.6 1 "falling" nil nil nil) cross(clip(VT("/C16") 0 9e-10) 0.6 1 "rising" nil nil nil)) - cross(clip(VT("/A15") 0 9e-10) 0.6 1 "rising" nil nil nil))
