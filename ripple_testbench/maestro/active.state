ADE simulation setup
Test project2_tb_adder_1: project2/tb_adder_ripple2/schematic, simulator spectre
  Models: /CMC/kits/tsmc_65nm/CRN65GP/TN65CMSP018K3_V1.0C/tsmcN65/../models/spectre/crn65gplus_2d5_lk_v1d0.scs[tt_bip, tt_dio, tt_dio_33, tt_mim, tt_dio_dnw, tt_dio_18, tt_bip_npn, tt_33, tt_rfrtmom, tt_mos_cap_25, tt_18, tt_disres, tt_res, tt_dio_na, tt_rfmos_33, tt_dio_hvt, tt_rfmvar, tt_rfmos_18, tt_na, tt_dio_na33, tt_dio_lvt, tt_rfres_sa, tt_na33, tt_dio_esd, tt_rfmim, tt_dio_25od33, tt_25od33, tt, tt_mos_cap, tt_dio_25, tt_dio_25ud18, tt_25, tt_rfmos, tt_25ud18, tt_dio_na25od33, tt_rfjvar, tt_rfmos_25, tt_rtmom, tt_na25od33, tt_dio_na25, tt_rfres_rpo, tt_hvt, tt_rfind, tt_rfmvar_25, tt_na25, tt_lvt]
  Temperature: 27
  Analysis tran: stop=4n
  Output S15 = cross(clip(VT("/S15") 0 7e-10) 0.6 1 "falling" nil nil nil) (unticked)
  Output C16 = cross(clip(VT("/C16") 0 8e-10) 0.6 1 "rising" nil nil nil) (unticked)
  Output A15 = cross(clip(VT("/A15") 0 7e-10) 0.6 1 "rising" nil nil nil) (unticked)
  Output toutB = (max(cross(clip(VT("/S15") 0 8e-10) 0.6 1 "rising" nil nil nil) cross(clip(VT("/C16") 0 8e-10) 0.6 1 "rising" nil nil nil)) - cross(clip(VT("/A15") 0 8e-10) 0.6 1 "rising" nil nil nil)) (unticked)
  Output toutC = (max(cross(clip(VT("/S14") 0 8e-10) 0.6 1 "rising" nil nil nil) cross(clip(VT("/C16") 0 8e-10) 0.6 1 "rising" nil nil nil)) - cross(clip(VT("/A15") 0 8e-10) 0.6 1 "rising" nil nil nil)) (unticked)
  Output power = (integ((abs(VT("/VDD")) * abs(IT("/V34/PLUS"))) 0 4e-09 " ") / 4e-09)
  Output PDP_A = ((max(cross(clip(VT("/S15") 0 9e-10) 0.6 1 "falling" nil nil nil) cross(clip(VT("/C16") 0 9e-10) 0.6 1 "rising" nil nil nil)) - cross(clip(VT("/A15") 0 9e-10) 0.6 1 "rising" nil nil nil)) * (integ((abs(VT("/VDD")) * abs(IT("/V34/PLUS"))) 0 4e-09 " ") / 4e-09))
  Output toutA = (max(cross(clip(VT("/S15") 0 9e-10) 0.6 1 "falling" nil nil nil) cross(clip(VT("/C16") 0 9e-10) 0.6 1 "rising" nil nil nil)) - cross(clip(VT("/A15") 0 9e-10) 0.6 1 "rising" nil nil nil))
  Output PDP_B = ((max(cross(clip(VT("/S15") 0 8e-10) 0.6 1 "rising" nil nil nil) cross(clip(VT("/C16") 0 8e-10) 0.6 1 "rising" nil nil nil)) - cross(clip(VT("/A15") 0 8e-10) 0.6 1 "rising" nil nil nil)) * (integ((abs(VT("/VDD")) * abs(IT("/V34/PLUS"))) 0 4e-09 " ") / 4e-09)) (unticked)
  Output PDP_C = ((max(cross(clip(VT("/S14") 0 8e-10) 0.6 1 "rising" nil nil nil) cross(clip(VT("/C16") 0 8e-10) 0.6 1 "rising" nil nil nil)) - cross(clip(VT("/A15") 0 8e-10) 0.6 1 "rising" nil nil nil)) * (integ((abs(VT("/VDD")) * abs(IT("/V34/PLUS"))) 0 4e-09 " ") / 4e-09)) (unticked)
  Output S14 = cross(clip(VT("/S14") 0 7e-10) 0.6 1 "falling" nil nil nil) (unticked)
  Output (max(cross(clip(VT("/S14") 0 9e-10) 0.6 1 "falling" nil nil nil) cross(clip(VT("/C16") 0 9e-10) 0.6 1 "rising" nil nil nil)) - cross(clip(VT("/A15") 0 9e-10) 0.6 1 "rising" nil nil nil)) (unticked)
  Signals: /A15, /B15, /A0, /VDD, /V34/PLUS (terminal), /S0, /S1, /S2, /S3, /S4, /S5, /S6, /S7, /S8, /S9, /S10, /S11, /S12, /S13, /S14, /S15, /C16
Run mode: Single Run, Sweeps and Corners
